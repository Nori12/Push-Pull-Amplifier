** Profile: "SCHEMATIC1-bias"  [ C:\Users\Nori\Desktop\ELT IV\Trabalho\Simulacao\amplificador_push_pull_ab-pspicefiles\schematic1\bias.sim ]

** Creating circuit file "bias.cir"
** WARNING: THIS AUTOMATICALLY GENERATED FILE MAY BE OVERWRITTEN BY SUBSEQUENT SIMULATIONS

*Libraries:
* Profile Libraries :
* Local Libraries :
* From [PSPICE NETLIST] section of C:\SPB_Data\cdssetup\OrCAD_PSpice\17.2.0\PSpice.ini file:
.lib "nomd.lib"

*Analysis directives:
.TRAN 1m 10m 9m 1u
.FOUR 1k 10 V([VO])
.OPTIONS ADVCONV
.PROBE64 V(alias(*)) I(alias(*)) W(alias(*)) D(alias(*)) NOISE(alias(*))
.INC "..\SCHEMATIC1.net"

.END
